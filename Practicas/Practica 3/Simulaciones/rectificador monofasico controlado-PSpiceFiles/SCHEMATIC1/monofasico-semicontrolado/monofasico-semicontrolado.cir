** Profile: "SCHEMATIC1-monofasico-semicontrolado"  [ C:\Users\emile\Desktop\practica 3 garabito\rectificador monofasico controlado-pspicefiles\schematic1\monofasico-semicontrolado.sim ]

** Creating circuit file "monofasico-semicontrolado.cir"
** WARNING: THIS AUTOMATICALLY GENERATED FILE MAY BE OVERWRITTEN BY SUBSEQUENT SIMULATIONS

*Libraries:
* Profile Libraries :
* Local Libraries :
* From [PSPICE NETLIST] section of C:\SPB_Data\cdssetup\OrCAD_PSpice/16.6.0/PSpice.ini file:
.lib "nom.lib"

*Analysis directives:
.TRAN  0 40ms 0 5ms
.OPTIONS ADVCONV
.PROBE64 V(alias(*)) I(alias(*)) W(alias(*)) D(alias(*)) NOISE(alias(*))
.INC "..\SCHEMATIC1.net"

.END
