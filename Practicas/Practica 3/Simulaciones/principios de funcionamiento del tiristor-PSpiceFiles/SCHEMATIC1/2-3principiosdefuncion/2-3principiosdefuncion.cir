** Profile: "SCHEMATIC1-2-3principiosdefuncion"  [ C:\Users\emile\Pictures\principios de funcionamiento del tiristor-PSpiceFiles\SCHEMATIC1\2-3principiosdefuncion.sim ]

** Creating circuit file "2-3principiosdefuncion.cir"
** WARNING: THIS AUTOMATICALLY GENERATED FILE MAY BE OVERWRITTEN BY SUBSEQUENT SIMULATIONS

*Libraries:
* Profile Libraries :
* Local Libraries :
* From [PSPICE NETLIST] section of C:\SPB_Data\cdssetup\OrCAD_PSpice\17.2.0\PSpice.ini file:
.lib "nomd.lib"

*Analysis directives:
.TRAN  0 40ms 0 5ms
.OPTIONS ADVCONV
.PROBE64 V(alias(*)) I(alias(*)) W(alias(*)) D(alias(*)) NOISE(alias(*))
.INC "..\SCHEMATIC1.net"

.END
